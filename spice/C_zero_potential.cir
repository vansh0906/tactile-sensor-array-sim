* Zero-potential readout, row 5 selected
* Python MNA result: V(o1) = -1.468353 V, V(o5) = -0.000110 V, V(o8) = -1.016636 V
Rdrv0 d0 r0 30
Rt0_0 r0 c0 10000000
Rt0_1 r0 c1 10000000
Rt0_2 r0 c2 10000000
Rt0_3 r0 c3 10000000
Rt0_4 r0 c4 10000000
Rt0_5 r0 c5 10000000
Rt0_6 r0 c6 10000000
Rt0_7 r0 c7 10000000
Rt0_8 r0 c8 1000
Rdrv1 d1 r1 30
Rt1_0 r1 c0 10000000
Rt1_1 r1 c1 765.940251
Rt1_2 r1 c2 10000000
Rt1_3 r1 c3 10000000
Rt1_4 r1 c4 10000000
Rt1_5 r1 c5 925.542252
Rt1_6 r1 c6 10000000
Rt1_7 r1 c7 10000000
Rt1_8 r1 c8 1000
Rdrv2 d2 r2 30
Rt2_0 r2 c0 10000000
Rt2_1 r2 c1 10000000
Rt2_2 r2 c2 10000000
Rt2_3 r2 c3 10000000
Rt2_4 r2 c4 10000000
Rt2_5 r2 c5 10000000
Rt2_6 r2 c6 10000000
Rt2_7 r2 c7 10000000
Rt2_8 r2 c8 1000
Rdrv3 d3 r3 30
Rt3_0 r3 c0 10000000
Rt3_1 r3 c1 10000000
Rt3_2 r3 c2 10000000
Rt3_3 r3 c3 10000000
Rt3_4 r3 c4 10000000
Rt3_5 r3 c5 10000000
Rt3_6 r3 c6 10000000
Rt3_7 r3 c7 10000000
Rt3_8 r3 c8 1000
Rdrv4 d4 r4 30
Rt4_0 r4 c0 10000000
Rt4_1 r4 c1 10000000
Rt4_2 r4 c2 10000000
Rt4_3 r4 c3 10000000
Rt4_4 r4 c4 10000000
Rt4_5 r4 c5 10000000
Rt4_6 r4 c6 10000000
Rt4_7 r4 c7 10000000
Rt4_8 r4 c8 1000
Rdrv5 d5 r5 30
Rt5_0 r5 c0 10000000
Rt5_1 r5 c1 686.99863
Rt5_2 r5 c2 10000000
Rt5_3 r5 c3 10000000
Rt5_4 r5 c4 10000000
Rt5_5 r5 c5 10000000
Rt5_6 r5 c6 10000000
Rt5_7 r5 c7 10000000
Rt5_8 r5 c8 1000
Rdrv6 d6 r6 30
Rt6_0 r6 c0 10000000
Rt6_1 r6 c1 10000000
Rt6_2 r6 c2 10000000
Rt6_3 r6 c3 10000000
Rt6_4 r6 c4 10000000
Rt6_5 r6 c5 10000000
Rt6_6 r6 c6 10000000
Rt6_7 r6 c7 10000000
Rt6_8 r6 c8 1000
Rdrv7 d7 r7 30
Rt7_0 r7 c0 10000000
Rt7_1 r7 c1 10000000
Rt7_2 r7 c2 10000000
Rt7_3 r7 c3 10000000
Rt7_4 r7 c4 10000000
Rt7_5 r7 c5 10000000
Rt7_6 r7 c6 10000000
Rt7_7 r7 c7 10000000
Rt7_8 r7 c8 1000
Rdrv8 d8 r8 30
Rt8_0 r8 c0 1000
Rt8_1 r8 c1 1000
Rt8_2 r8 c2 1000
Rt8_3 r8 c3 1000
Rt8_4 r8 c4 1000
Rt8_5 r8 c5 1000
Rt8_6 r8 c6 1000
Rt8_7 r8 c7 1000
Rt8_8 r8 c8 1000
Rcol0 c0 t0 0.05
Rf0 t0 o0 330.623876
Rcol1 c1 t1 0.05
Rf1 t1 o1 328.27493
Rcol2 c2 t2 0.05
Rf2 t2 o2 328.63689
Rcol3 c3 t3 0.05
Rf3 t3 o3 321.943158
Rcol4 c4 t4 0.05
Rf4 t4 o4 335.939034
Rcol5 c5 t5 0.05
Rf5 t5 o5 333.775747
Rcol6 c6 t6 0.05
Rf6 t6 o6 328.926105
Rcol7 c7 t7 0.05
Rf7 t7 o7 332.553562
Rcol8 c8 t8 0.05
Rf8 t8 o8 330.927995
Vd0 d0 0 0
Vd1 d1 0 0
Vd2 d2 0 0
Vd3 d3 0 0
Vd4 d4 0 0
Vd5 d5 0 3.3
Vd6 d6 0 0
Vd7 d7 0 0
Vd8 d8 0 0
Eamp0 o0 0 0 t0 100000
Eamp1 o1 0 0 t1 100000
Eamp2 o2 0 0 t2 100000
Eamp3 o3 0 0 t3 100000
Eamp4 o4 0 0 t4 100000
Eamp5 o5 0 0 t5 100000
Eamp6 o6 0 0 t6 100000
Eamp7 o7 0 0 t7 100000
Eamp8 o8 0 0 t8 100000
.op
.end
