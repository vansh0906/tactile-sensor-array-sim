* Passive matrix, divider readout, floating unselected lines, selected taxel r5 c5
* Python MNA result: V(out) = 0.967432 V
Rt0_0 r0 c0 10000000
Rt0_1 r0 c1 10000000
Rt0_2 r0 c2 10000000
Rt0_3 r0 c3 10000000
Rt0_4 r0 c4 10000000
Rt0_5 r0 c5 10000000
Rt0_6 r0 c6 10000000
Rt0_7 r0 c7 10000000
Rt1_0 r1 c0 10000000
Rt1_1 r1 c1 765.940251
Rt1_2 r1 c2 10000000
Rt1_3 r1 c3 10000000
Rt1_4 r1 c4 10000000
Rt1_5 r1 c5 925.542252
Rt1_6 r1 c6 10000000
Rt1_7 r1 c7 10000000
Rt2_0 r2 c0 10000000
Rt2_1 r2 c1 10000000
Rt2_2 r2 c2 10000000
Rt2_3 r2 c3 10000000
Rt2_4 r2 c4 10000000
Rt2_5 r2 c5 10000000
Rt2_6 r2 c6 10000000
Rt2_7 r2 c7 10000000
Rt3_0 r3 c0 10000000
Rt3_1 r3 c1 10000000
Rt3_2 r3 c2 10000000
Rt3_3 r3 c3 10000000
Rt3_4 r3 c4 10000000
Rt3_5 r3 c5 10000000
Rt3_6 r3 c6 10000000
Rt3_7 r3 c7 10000000
Rt4_0 r4 c0 10000000
Rt4_1 r4 c1 10000000
Rt4_2 r4 c2 10000000
Rt4_3 r4 c3 10000000
Rt4_4 r4 c4 10000000
Rt4_5 r4 c5 10000000
Rt4_6 r4 c6 10000000
Rt4_7 r4 c7 10000000
Rt5_0 r5 c0 10000000
Rt5_1 r5 c1 686.99863
Rt5_2 r5 c2 10000000
Rt5_3 r5 c3 10000000
Rt5_4 r5 c4 10000000
Rt5_5 r5 c5 10000000
Rt5_6 r5 c6 10000000
Rt5_7 r5 c7 10000000
Rt6_0 r6 c0 10000000
Rt6_1 r6 c1 10000000
Rt6_2 r6 c2 10000000
Rt6_3 r6 c3 10000000
Rt6_4 r6 c4 10000000
Rt6_5 r6 c5 10000000
Rt6_6 r6 c6 10000000
Rt6_7 r6 c7 10000000
Rt7_0 r7 c0 10000000
Rt7_1 r7 c1 10000000
Rt7_2 r7 c2 10000000
Rt7_3 r7 c3 10000000
Rt7_4 r7 c4 10000000
Rt7_5 r7 c5 10000000
Rt7_6 r7 c6 10000000
Rt7_7 r7 c7 10000000
Rdrv5 d5 r5 30
Rmux c5 out 5
Rsense out 0 1000
Vd5 d5 0 3.3
.op
.end
